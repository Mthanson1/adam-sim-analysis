* Load cell filter step response: 1 V differential step at t = 100 us (scale linearly)
.include loadcell_filter.inc
Vd vd 0 PWL(0 0 100u 0 100.1u 1)
X1 vd p n loadcell_filter
.tran 0.5u 5m 0 0.5u
.end
